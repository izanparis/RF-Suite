* Auto universal passive shunt capacitor model V2
* Generated from 2-port shunt-through S2P
* Terminals: P = shunt node, G = ground
.SUBCKT C_10NF_100_1000MHZ_1000PTS P G

RPAR P G 8.088073555751e+03
CPAR P G 1.525244291650e-11

RMAIN P N_MAIN_R 1.603483370575e+01
LMAIN N_MAIN_R N_MAIN_L 1.863034477613e-09
CMAIN N_MAIN_L G 8.677462984747e-11

REX1 P N_EX1_R 3.976997646809e-01
LEX1 N_EX1_R N_EX1_L 3.288522718164e-09
CEX1 N_EX1_L G 7.785825036789e-09

.ENDS C_10NF_100_1000MHZ_1000PTS

* Example: XCAP node_shunt 0 C_10NF_100_1000MHZ_1000PTS
